//techsweep.scs
include  "./models/28nm/toplevel.scs" section=top_tt
include "techsweep_params.scs"
include "./models/28nm/toplevel.scs" section=pre_simu
save mn
save mp
parameters gs=0 ds=0
vnoi     (vx  0)         vsource dc=0
vdsn     (vdn vx)        vsource dc=ds
vgsn     (vgn 0)         vsource dc=gs
vbsn     (vbn 0)         vsource dc=-sb
vdsp     (vdp vx)        vsource dc=-ds
vgsp     (vgp 0)         vsource dc=-gs
vbsp     (vbp 0)         vsource dc=sb

//NOTE: YOUR MODELS SHOULD BE SET UP SUCH THAT THE STRESS PARAMS (SA, SB, etc.) ARE AUTOMATICALLY COMPUTED
mn       (vdn vgn 0 vbn) nch_lvt_mac  l=length*1e-6 w=4e-6 nf=4
mp       (vdp vgp 0 vbp) pch_lvt_mac  l=length*1e-6 w=4e-6 nf=4

simOptions options gmin=1e-13 reltol=1e-4 vabstol=1e-6 iabstol=1e-10 temp=27 tnom=27 rawfmt=psfbin rawfile="./techsweep.raw"
sweepvds sweep param=ds start=0 stop=9.000000e-01 step=2.500000e-02 {
   sweepvgs dc param=gs start=0 stop=9.000000e-01 step=2.500000e-02
}
sweepvds_noise sweep param=ds start=0 stop=9.000000e-01 step=2.500000e-02 {
   sweepvgs_noise noise freq=1 oprobe=vnoi param=gs start=0 stop=9.000000e-01 step=2.500000e-02
}
